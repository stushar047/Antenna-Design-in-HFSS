# Ansys Electronics Desktop project, version 2019.3
materials:
  vacuum: permittivity=1
  copper: permeability=0.999991 conductivity=58000000
  Rogers RO4350 (tm): permittivity=3.66 dielectric_loss_tangent=0.004

design HFSSDesign1 (HFSS, DrivenTerminal, model units mm)
variables:
  armwidth = 1.5mm
  antennaheight = 15mm
  rec_x = 50mm
  rec_y = 40mm
  La = 3mm
  substrate = 50mm
  h = 31mil
  height = 20mm
  QW = 20mm
geometry:
  arm1_3D = rectangle(corner=(0mm, -10mm, 0mm), x_size=armwidth, y_size=antennaheight)
  arm1_3D.spiral(IsSpiral XCenter=0mm YCenter=0mm ZCenter=0mm XStartDir=0mm YStartDir=-0.8mm ZStartDir=0mm NumThread=2 RightHand=true RadiusIncrement=10mm)
  arm1_3D.rotate(axis=X, angle=90deg)
  Rectangle1 = rectangle(corner=(-rec_x/2, -rec_y/2, 0mm), x_size=rec_x, y_size=rec_y)
  Rectangle1.subtract(arm1_3D)
  arm_1 = rectangle(corner=(-rec_x/2, -rec_y/2, 0mm), x_size=rec_x, y_size=rec_y)
  arm_1.subtract(Rectangle1)
  Airgap = rectangle(corner=(-La/2, -0.75*armwidth/2, 0mm), x_size=La, y_size=0.75*armwidth)
  Airgap.rotate(axis=Z, angle=-20deg)
  Airgap_1 = Airgap.copy()
  Airgap.delete()
  arm_1.subtract(Airgap_1)
  Source = rectangle(corner=(-La/2, -0.6*armwidth/2, 0mm), x_size=La, y_size=0.6*armwidth)
  Source.rotate(axis=Z, angle=-20deg)
  Ground_Plane = rectangle(corner=(-substrate/2, -substrate/2, -h), x_size=substrate, y_size=substrate)
  Substrate [Rogers RO4350 (tm)] = box(corner=(-substrate/2, -substrate/2, 0mm), size=(substrate, substrate, -h))
  Airbox [vacuum] = box(corner=(-substrate/2, -substrate/2, -(h+1mils)), size=(substrate, substrate, QW))
  arms = rectangle(corner=(-rec_x/2, -rec_y/2, 0mm), x_size=rec_x, y_size=rec_y)
  Rectangle3 = rectangle(corner=(-rec_x/2, -rec_y/2, 0mm), x_size=rec_x, y_size=rec_y)
  arm2_3D1 = rectangle(corner=(0mm, -10mm, 0mm), x_size=armwidth, y_size=antennaheight)
  arm2_3D1.spiral(IsSpiral XCenter=0mm YCenter=0mm ZCenter=0mm XStartDir=0mm YStartDir=-0.8mm ZStartDir=0mm NumThread=2 RightHand=false RadiusIncrement=10mm)
  arm2_3D1.rotate(axis=X, angle=90deg)
  arm2_3D1.mirror(point=(0mm, 2mm, 0mm), normal=(-1mm, 0mm, 0mm))
  Rectangle3.subtract(arm2_3D1)
  arms.subtract(Rectangle3)
  Airgap1 = rectangle(corner=(-La/2, -0.75*armwidth/2, 0mm), x_size=La, y_size=0.75*armwidth)
  Airgap1.rotate(axis=Z, angle=-20deg)
  arms.subtract(Airgap1)
  arms.unite(arm_1)
boundaries and excitations:
  PerfE_Ground: Perfect E Objects=Ground_Plane
  Rad1: Radiation Objects=Airbox
  PerfE_arms: Perfect E Objects=arms
  arms_T2: Terminal port=3 Edges=arms.edge(#315) TerminalResistance=50ohm
  3: Lumped Port Faces=Source.face(#333) Impedance=50ohm
  reference conductors: Ground_Plane
setups:
  Setup1: HfssDriven AdaptMultipleFreqs MultipleAdaptiveFreqsSetup{Broadband{Low=30GHz High=100GHz}} MaxDeltaS=0.02 MaximumPasses=10 MinimumPasses=1 MinimumConvergedPasses=1 PercentRefinement=30 BasisOrder=1 PortAccuracy=2
    sweep Sweep: 30GHz to 100GHz step 10GHz; Type=Fast SaveFields
source amplitudes:
  3:1: 1V 0deg
radiation setups:
  Infinite Sphere1: Infinite Sphere Theta=0deg..180deg step 2deg Phi=0deg..180deg step 10deg
  Infinite Sphere2: Infinite Sphere Theta=0deg..180deg step 10deg Phi=0deg..360deg step 10deg
